* 6T SRAM Cell - check that the ckt have no error

* level-1 model for 6T SRAM study (temporary, education-level values)
.model nmos nmos level=1 vto=0.5 kp=200u gamma=0.4 lambda=0.05 tox=4n cgso=3e-10 cgdo=3e-10 cj=1e-3 cjsw=2e-10
.model pmos pmos level=1 vto=-0.5 kp=80u gamma=0.4 lambda=0.05 tox=4n cgso=3e-10 cgdo=3e-10 cj=1e-3 cjsw=2e-10
.param vdd=1.8 lmin=0.18u

Vdd vdd 0 {vdd}
Vwl wl 0 0
Vbl bl 0 {vdd}
Vblb blb 0 {vdd}

Mp1 q qb vdd vdd pmos W=0.36u L={lmin}
Mp2 qb q vdd vdd pmos W=0.36u L={lmin}
Mn1 q qb GND GND nmos W=0.72u L={lmin}
Mn2 qb q GND GND nmos W=0.72u L={lmin}
Matl bl wl q GND nmos W=0.36u L={lmin}
Matr blb wl qb GND nmos W=0.36u L={lmin}

.ic v(q)={vdd} v(qb)=0
.tran 10p 50n

.control
run
meas tran q_end find v(q) at=50ns
meas tran qb_end find v(qb) at=50ns
.endc
.end
