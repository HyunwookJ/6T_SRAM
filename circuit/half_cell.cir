* Half of 6T SRAM Cell - read and hold check

.model nmos nmos level=1 vto=0.5 kp=200u gamma=0.4 lambda=0.05 tox=4n cgso=3e-10 cgdo=3e-10 cj=1e-3 cjsw=2e-10
.model pmos pmos level=1 vto=-0.5 kp=80u gamma=0.4 lambda=0.05 tox=4n cgso=3e-10 cgdo=3e-10 cj=1e-3 cjsw=2e-10
.param vdd=1.8 lmin=0.18u

Vdd vdd 0 {vdd}
Vwl wl 0 {vdd}
Vbl bl 0 {vdd}
Vblb blb 0 {vdd}
Vin in 0 0

Mp1 out in vdd vdd pmos W=0.36u L={lmin}
Mn1 out in GND GND nmos W=0.72u L={lmin}
Matl bl wl out GND nmos W=0.36u L={lmin}

.dc Vin 0 {vdd} 0.01

.control
run
set wr_vecnames
wrdata vtc_read.txt v(out)
alter vwl dc=0
run
wrdata vtc_hold.txt v(out)
.endc
.end
