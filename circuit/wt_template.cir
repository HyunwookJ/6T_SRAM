* 6T SRAM Cell - write time check

.model nmos nmos level=1 vto=0.5 kp=200u gamma=0.4 lambda=0.05 tox=4n cgso=3e-10 cgdo=3e-10 cj=1e-3 cjsw=2e-10
.model pmos pmos level=1 vto=-0.5 kp=80u gamma=0.4 lambda=0.05 tox=4n cgso=3e-10 cgdo=3e-10 cj=1e-3 cjsw=2e-10
.param vdd=1.8 lmin=0.18u

Vdd vdd 0 {vdd}
Vwl wl 0 PULSE(0 {vdd} 0.1n 20p 20p 2n 4n)
Vbl bl 0 0
Vblb blb 0 {vdd}

Mp1 q qb vdd vdd pmos W=WPU L={lmin}
Mp2 qb q vdd vdd pmos W=WPU L={lmin}
Mn1 q qb GND GND nmos W=0.72u L={lmin}
Mn2 qb q GND GND nmos W=0.72u L={lmin}
Matl bl wl q GND nmos W=0.36u L={lmin}
Matr blb wl qb GND nmos W=0.36u L={lmin}

.ic v(q)={vdd} v(qb)=0
.tran 1p 2n uic

.control
run
meas tran twr trig v(wl) val=0.9 rise=1 targ v(q) val=0.9 fall=1
.endc
.end
