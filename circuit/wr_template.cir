* 6T SRAM Cell - check that the ckt have no error

.model nmos nmos level=1 vto=0.5 kp=200u gamma=0.4 lambda=0.05 tox=4n cgso=3e-10 cgdo=3e-10 cj=1e-3 cjsw=2e-10
.model pmos pmos level=1 vto=-0.5 kp=80u gamma=0.4 lambda=0.05 tox=4n cgso=3e-10 cgdo=3e-10 cj=1e-3 cjsw=2e-10
.param vdd=1.8 lmin=0.18u

Vdd vdd 0 {vdd}
Vwl wl 0 {vdd}
Vbl bl 0 {vdd}
Vblb blb 0 {vdd}

* Template(WPU, WRITE_FILE) → Filling from py → tmp.cir → ngspice
Mp1 q qb vdd vdd pmos W=WPU L={lmin}
Mp2 qb q vdd vdd pmos W=WPU L={lmin}
Mn1 q qb GND GND nmos W=0.72u L={lmin}
Mn2 qb q GND GND nmos W=0.72u L={lmin}
Matl bl wl q GND nmos W=0.36u L={lmin}
Matr blb wl qb GND nmos W=0.36u L={lmin}

.nodeset v(q)={vdd} v(qb)=0
.dc Vbl 1.8 0 -0.002

.control
run
set wr_vecnames
wrdata WRITE_FILE v(q) v(qb)
.endc
.end
